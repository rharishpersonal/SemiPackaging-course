# Ansys Electronics Desktop project, version 2022.2
materials:
  vacuum: permittivity=1
  copper: permeability=0.999991 conductivity=58000000
  silicon: permittivity=11.9
  FR4_epoxy: permittivity=4.4 dielectric_loss_tangent=0.02
  modified_epoxy: permittivity=4.2 dielectric_loss_tangent=0.02
  gold: permeability=0.99996 conductivity=41000000
  epoxy_Kevlar_xy: permittivity=3.6

design Q3DDesign1 (Q3D Extractor, model units mm)
options: SParamCalcMethod=EqTransLine Calculate_Lossy_Dielectrics
geometry:
  Die [silicon] = rectangle(corner=(0mm, 0mm, 0mm), x_size=2mm, y_size=2mm)
  Die.thicken(0.15mm)
  Substrate [FR4_epoxy] = rectangle(corner=(-1mm, -1mm, -0.1mm), x_size=4mm, y_size=4mm)
  Substrate.thicken(-0.4mm)
  Dia_Attach [modified_epoxy] = rectangle(corner=(0mm, 0mm, 0mm), x_size=2mm, y_size=2mm)
  Dia_Attach.thicken(-0.1mm)
  DiebondPad1 [copper] = rectangle(corner=(0.15mm, 0.15mm, 0.15mm), x_size=0.2mm, y_size=0.2mm)
  DiebondPad1.thicken(0.005mm)
  SubstrateBondPad1 [copper] = rectangle(corner=(0.15mm, -0.5mm, -0.1mm), x_size=0.2mm, y_size=0.2mm)
  SubstrateBondPad2 [copper] = rectangle(corner=(0.55mm, -0.5mm, -0.1mm), x_size=0.2mm, y_size=0.2mm)
  SubstrateBondPad3 [copper] = rectangle(corner=(0.95mm, -0.5mm, -0.1mm), x_size=0.2mm, y_size=0.2mm)
  SubstrateBondPad4 [copper] = rectangle(corner=(1.35mm, -0.5mm, -0.1mm), x_size=0.2mm, y_size=0.2mm)
  DiebondPad2 [copper] = rectangle(corner=(0.55mm, 0.15mm, 0.15mm), x_size=0.2mm, y_size=0.2mm)
  DiebondPad2.thicken(0.005mm)
  DiebondPad3 [copper] = rectangle(corner=(0.95mm, 0.15mm, 0.15mm), x_size=0.2mm, y_size=0.2mm)
  DiebondPad3.thicken(0.005mm)
  DiebondPad4 [copper] = rectangle(corner=(1.35mm, 0.15mm, 0.15mm), x_size=0.2mm, y_size=0.2mm)
  DiebondPad4.thicken(0.005mm)
  Bondwire1 [gold] = bondwire(WireType=JEDEC_5Points WireDiameter=0.025mm NumSides=6 XPadPos=0.25mm YPadPos=0.25mm ZPadPos=0.155mm XDir=0mm YDir=-0.65mm ZDir=0mm Distance=0.65mm h1=0.2mm h2=0.255mm alpha=80deg beta=5deg WhichAxis=Z)
  Bondwire2 [gold] = bondwire(WireType=JEDEC_5Points WireDiameter=0.025mm NumSides=6 XPadPos=0.65mm YPadPos=0.25mm ZPadPos=0.155mm XDir=0mm YDir=-0.65mm ZDir=0mm Distance=0.65mm h1=0.2mm h2=0.255mm alpha=80deg beta=5deg WhichAxis=Z)
  Bondwire3 [gold] = bondwire(WireType=JEDEC_5Points WireDiameter=0.025mm NumSides=6 XPadPos=1.05mm YPadPos=0.25mm ZPadPos=0.155mm XDir=0mm YDir=-0.65mm ZDir=0mm Distance=0.65mm h1=0.2mm h2=0.255mm alpha=80deg beta=5deg WhichAxis=Z)
  Bondwire4 [gold] = bondwire(WireType=JEDEC_5Points WireDiameter=0.025mm NumSides=6 XPadPos=1.45mm YPadPos=0.25mm ZPadPos=0.155mm XDir=0mm YDir=-0.65mm ZDir=0mm Distance=0.65mm h1=0.2mm h2=0.255mm alpha=80deg beta=5deg WhichAxis=Z)
  Mold [epoxy_Kevlar_xy] = rectangle(corner=(-1mm, -1mm, -0.1mm), x_size=4mm, y_size=4mm)
  Mold.thicken(1.5mm)
